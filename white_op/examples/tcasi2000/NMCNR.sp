.subckt opamp NodeInput NodeOutput NodeGround
*main amplification stages and associated parasitics
G_1 Node1 NodeGround NodeInput NodeGround 'G_1'
Rprs_1 Node1 NodeGround 'A_1/G_1'
Cprs_1 Node1 NodeGround 'G_2/6.28*5n'
G_2 Node2 NodeGround Node1 NodeGround '-1*G_2'
Rprs_2 Node2 NodeGround 'A_2/G_2'
Cprs_2 Node2 NodeGround 'G_3/6.28*5n'
G_3 NodeOutput NodeGround Node2 NodeGround 'G_3'
Rprs_3 NodeOutput NodeGround 'A_3/G_3'
*loads
C_L NodeOutput NodeGround 10p
R_L NodeOutput NodeGround 10Meg
*simple nested miller compensation with nulling resistor
C_m1 Node1 Node3 'C_m1'
C_m2 Node2 Node3 'C_m2'
R_m Node3 NodeOutput 'R_m'
.ends
